//Verilog-AMS HDL
//
// Andrew Smith
// 04092020
//
// This models the board capacitance, traces, and package impedence from the
// intel EVSD 11.1 (2009)
//

`include "constants.vams"
`include "disciplines.vams"
`include "resistor.vams"

`timescale 1ns/1ps

module my_cap(p, n);
  inout p, n;
  electrical p, n;
  parameter real C=0;

  analog begin
    I(p,n) <+ C * ddt(V(p,n));
  end
endmodule

module my_ind(p, n);
  inout p, n;
  electrical p, n;
  parameter real L=0;

  analog begin
    V(p,n) <+ L * ddt(I(p,n));
  end
endmodule

module my_real_capacitor(p, n);
  inout p, n;
  electrical p, n;
  electrical n1, n2;
  parameter real C=1u;
  parameter real ESL=0;
  parameter real ESR=1u;

  my_cap#(.C(C)) C1(p, n1);
  my_res#(.R(100k)) RESR1(n1, n2);
  my_ind#(.L(ESL)) LESL(n1, n2);
  my_res#(.R(ESR)) RESR(n2, n);
endmodule

module pcb_trace(p, n);
  inout p, n;
  electrical p, n;
  electrical n1;
  parameter real ESL=0;
  parameter real ESR=1u;

  my_ind#(.L(ESL)) LESL(p, n1);
  my_res#(.R(ESR)) RESR(n1, n);
endmodule

module board_package (vin, vout, vsense_in, vsense_out, gnd);
	inout vin, vout, gnd;
  output vsense_in, vsense_out;
	electrical vin, vout, vsense_in, vsense_out, n1, n2, n3, gnd;

  // Supply Load Resistor
  my_res#(.R(2500u)) rsupply(vin, n1);

  // Ceramic Bulk
  my_real_capacitor#(.C(990u), .ESL(423p), .ESR(2m)) c_electrolytic_bulk(n1, gnd);

  // Ceramic Bulk
  my_real_capacitor#(.C(264u), .ESL(45p), .ESR(400u)) c_ceramic_bulk(n1, gnd);

  // Ceramic Socket
  my_real_capacitor#(.C(1222u), .ESL(20p), .ESR(150u)) c_ceramic_socket(n2, gnd);

  my_res#(.R(100k)) r1(n2, gnd);

  // Motherboard traces
  pcb_trace#(.ESL(90p), .ESR(200u)) trace(n1, n2);

  my_res#(.R(100k)) ra(n1, gnd);

  // Package
  pcb_trace#(.ESL(12p), .ESR(400u)) package(n2, n3);

  my_res#(.R(100k)) rb(n3, gnd);

  // output sense resistor
  my_res#(.R(1u)) rout(n3, vout);

  analog begin
    V(vsense_in, gnd) <+ V(n1, gnd);
    V(vsense_out, gnd) <+ V(n3, gnd);
  end

endmodule
