/*
 * Copyright (c) 2020 Andrew Smith
 *
 * Permission is hereby granted, free of charge, to any person obtaining a copy
 * of this software and associated documentation files (the "Software"), to deal
 * in the Software without restriction, including without limitation the rights
 * to use, copy, modify, merge, publish, distribute, sublicense, and/or sell
 * copies of the Software, and to permit persons to whom the Software is
 * furnished to do so, subject to the following conditions:
 *
 * The above copyright notice and this permission notice shall be included in all
 * copies or substantial portions of the Software.
 *
 * THE SOFTWARE IS PROVIDED "AS IS", WITHOUT WARRANTY OF ANY KIND, EXPRESS OR
 * IMPLIED, INCLUDING BUT NOT LIMITED TO THE WARRANTIES OF MERCHANTABILITY,
 * FITNESS FOR A PARTICULAR PURPOSE AND NONINFRINGEMENT. IN NO EVENT SHALL THE
 * AUTHORS OR COPYRIGHT HOLDERS BE LIABLE FOR ANY CLAIM, DAMAGES OR OTHER
 * LIABILITY, WHETHER IN AN ACTION OF CONTRACT, TORT OR OTHERWISE, ARISING FROM,
 * OUT OF OR IN CONNECTION WITH THE SOFTWARE OR THE USE OR OTHER DEALINGS IN THE
 * SOFTWARE.
 */

/*
 * Verilog-AMS HDL
 *
 * This models the board capacitance, traces, and package impedence from the
 * intel EVSD 11.1 (2009)
 */

`ifndef INTEL_PDN_VAMS
`define INTEL_PDN_VAMS

`include "constants.vams"
`include "disciplines.vams"
`include "resistor.vams"
`include "inductor.vams"
`include "capacitor.vams"
`include "pdn_stage.vams"

`timescale 1ps/1ps

/*
 * Module intel_power_distribution_network_m
 *
 *  Model of the PCB, Package, and Die Parasitic Inductances and Resistances.
 *  Modeled as 3 PDN Stages in series. For an Intel "Mobile" processor.
 *
 *    vin - Input Voltage (From ideal supply)
 *    vout - Output Voltage (To Load Model)
 *    vvrm - Voltage at the output of the vrm model
 *    vpcb - voltage at the output of the pcb model
 *    vpack - voltage at the output of the package model
 *    vdie - voltage at the output of the die model
 *    gnd - ground net
 */
module intel_power_distribution_network_m(vin, vout, vvrm, vpcb, vpack, vdie, iin, iout, gnd);
	inout vin, vout, gnd;
  output vvrm, vpcb, vpack, vdie, iin, iout;
	electrical vin, vout, iin, iout, vvrm, vpcb, vpack, vdie, n1, n2, n3, n4, gnd;

`ifdef FULL_INTEL_PDN
  // Essential for probing
  my_res#(.R(1n)) ri(vin, n1);

  pdn_stage#(.C_STAGE(850u),  .N_CAP(1), .L_STAGE(250p),   .R_STAGE(3.5m)) pcb(n1, n2, gnd);
  pdn_stage#(.C_STAGE(30u),   .N_CAP(1), .L_STAGE(35p),    .R_STAGE(2m))   package(n2, n3, gnd);
  pdn_stage#(.C_STAGE(600n),  .N_CAP(1), .L_STAGE(30p),    .R_STAGE(3m))   die(n3, n4, gnd);

  // Essential for probing
  my_res#(.R(1n)) ro(n4, vout);
`else
  // Essential for probing
  my_res#(.R(1n)) ri(vin, n1);

  pdn_stage#(.C_STAGE(0u),    .N_CAP(1), .L_STAGE(0p),     .R_STAGE(1n)) pcb(n1, n2, gnd);
  pdn_stage#(.C_STAGE(0u),    .N_CAP(1), .L_STAGE(0p),     .R_STAGE(1n)) package(n2, n3, gnd);
  pdn_stage#(.C_STAGE(600n),  .N_CAP(1), .L_STAGE(30p),    .R_STAGE(3m)) die(n3, n4, gnd);

  // Essential for probing
  my_res#(.R(1n)) ro(n4, vout);
`endif

  analog begin
    V(vvrm, gnd) <+ V(n1, gnd);
    V(vpcb, gnd) <+ V(n2, gnd);
    V(vpack, gnd) <+ V(n3, gnd);
    V(vdie, gnd) <+ V(n4, gnd);
    V(iin, gnd) <+ I(vin, n1);
    V(iout, gnd) <+ I(n4, vout);
  end
endmodule

/*
 * Module intel_power_distribution_network_dt
 *
 *  Model of the PCB, Package, and Die Parasitic Inductances and Resistances.
 *  Modeled as 3 PDN Stages in series. For an Intel "Desktop" processor.
 *
 *    vin - Input Voltage (From ideal supply)
 *    vout - Output Voltage (To Load Model)
 *    vvrm - Voltage at the output of the vrm model
 *    vpcb - voltage at the output of the pcb model
 *    vpack - voltage at the output of the package model
 *    vdie - voltage at the output of the die model
 *    gnd - ground net
 */
module intel_power_distribution_network_dt(vin, vout, vvrm, vpcb, vpack, vdie, iin, iout, gnd);
	inout vin, vout, gnd;
  output vvrm, vpcb, vpack, vdie, iin, iout;
	electrical vin, vout, iin, iout, vvrm, vpcb, vpack, vdie, n1, n2, n3, n4, gnd;

`ifdef FULL_INTEL_PDN
  // Essential for probing
  my_res#(.R(1n)) ri(vin, n1);

  pdn_stage#(.C_STAGE(1400u),  .N_CAP(1), .L_STAGE(400p),   .R_STAGE(1.25m))   pcb(n1, n2, gnd);
  pdn_stage#(.C_STAGE(60u),    .N_CAP(1), .L_STAGE(35p),    .R_STAGE(1.25m))   package(n2, n3, gnd);
  pdn_stage#(.C_STAGE(1.2u),   .N_CAP(1), .L_STAGE(30p),    .R_STAGE(3m))      die(n3, n4, gnd);

  // Essential for probing
  my_res#(.R(1n)) ro(n4, vout);
`else
  // Essential for probing
  my_res#(.R(1n)) ri(vin, n1);

  pdn_stage#(.C_STAGE(0u),      .N_CAP(1), .L_STAGE(0p),     .R_STAGE(1n)) pcb(n1, n2, gnd);
  pdn_stage#(.C_STAGE(0u),      .N_CAP(1), .L_STAGE(0p),     .R_STAGE(1n)) package(n2, n3, gnd);
  pdn_stage#(.C_STAGE(1.2u),    .N_CAP(1), .L_STAGE(30p),    .R_STAGE(3m)) die(n3, n4, gnd);

  // Essential for probing
  my_res#(.R(1n)) ro(n4, vout);
`endif

  analog begin
    V(vvrm, gnd) <+ V(n1, gnd);
    V(vpcb, gnd) <+ V(n2, gnd);
    V(vpack, gnd) <+ V(n3, gnd);
    V(vdie, gnd) <+ V(n4, gnd);
    V(iin, gnd) <+ I(vin, n1);
    V(iout, gnd) <+ I(n4, vout);
  end
endmodule

`endif // INTEL_PDN_VAMS
