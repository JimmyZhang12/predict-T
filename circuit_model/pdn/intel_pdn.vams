/*
 * Copyright (c) 2020 Andrew Smith
 *
 * Permission is hereby granted, free of charge, to any person obtaining a copy
 * of this software and associated documentation files (the "Software"), to deal
 * in the Software without restriction, including without limitation the rights
 * to use, copy, modify, merge, publish, distribute, sublicense, and/or sell
 * copies of the Software, and to permit persons to whom the Software is
 * furnished to do so, subject to the following conditions:
 *
 * The above copyright notice and this permission notice shall be included in all
 * copies or substantial portions of the Software.
 *
 * THE SOFTWARE IS PROVIDED "AS IS", WITHOUT WARRANTY OF ANY KIND, EXPRESS OR
 * IMPLIED, INCLUDING BUT NOT LIMITED TO THE WARRANTIES OF MERCHANTABILITY,
 * FITNESS FOR A PARTICULAR PURPOSE AND NONINFRINGEMENT. IN NO EVENT SHALL THE
 * AUTHORS OR COPYRIGHT HOLDERS BE LIABLE FOR ANY CLAIM, DAMAGES OR OTHER
 * LIABILITY, WHETHER IN AN ACTION OF CONTRACT, TORT OR OTHERWISE, ARISING FROM,
 * OUT OF OR IN CONNECTION WITH THE SOFTWARE OR THE USE OR OTHER DEALINGS IN THE
 * SOFTWARE.
 */

/*
 * Verilog-AMS HDL
 *
 * This models the board capacitance, traces, and package impedence from the
 * intel EVSD 11.1 (2009)
 */

`ifndef INTEL_PDN_VAMS
`define INTEL_PDN_VAMS

`include "constants.vams"
`include "disciplines.vams"
`include "resistor.vams"
`include "inductor.vams"
`include "capacitor.vams"

`timescale 1ps/1ps

module pcb_trace(p, n);
  inout p, n;
  electrical p, n;
  electrical n1;
  parameter real ESL=0;
  parameter real ESR=1u;

  my_ind#(.L(ESL)) LESL(p, n1);
  my_res#(.R(ESR)) RESR(n1, n);
endmodule

module board_package_intel_server (vin, vout, vsense_in, vsense_out, gnd);
	inout vin, vout, gnd;
  output vsense_in, vsense_out;
	electrical vin, vout, vsense_in, vsense_out, n1, n2, n3, n4, gnd;

//  // Supply Load Resistor
//  my_res#(.R(1u)) rsupply(vin, n1);
//
//  my_res#(.R(200u)) rwire1(n1, n2);
//
//  // Ceramic Bulk
//  my_real_cap#(.C(990u), .ESL(423p), .ESR(2m)) c_electrolytic_bulk(n2, gnd);
//
//  // Ceramic Bulk
//  my_real_cap#(.C(264u), .ESL(45p), .ESR(400u)) c_ceramic_bulk(n2, gnd);
//
//  // Ceramic Socket
//  my_real_cap#(.C(1222u), .ESL(20p), .ESR(150u)) c_ceramic_socket(n3, gnd);
//
//  //my_res#(.R(100k)) r1(n3, gnd);
//  //my_res#(.R(100k)) ra(n2, gnd);
//  //my_res#(.R(100k)) rb(n4, gnd);
//
//  // Motherboard traces
//  pcb_trace#(.ESL(90p), .ESR(200u)) trace(n2, n3);
//
//  // Package
//  pcb_trace#(.ESL(12p), .ESR(400u)) package(n3, n4);
//
//  // output sense resistor
//  my_res#(.R(1u)) rout(n4, vout);

  // output sense resistor
  my_res#(.R(1u)) rout(vin, vout);

  analog begin
//    V(vsense_in, gnd) <+ V(n1, gnd);
//    V(vsense_out, gnd) <+ V(n4, gnd);
    V(vsense_in, gnd) <+ V(vin, gnd);
    V(vsense_out, gnd) <+ V(vout, gnd);
  end
endmodule

module board_package_laptop (vin, vout, vsense_in, vsense_out, gnd);
	inout vin, vout, gnd;
  output vsense_in, vsense_out;
	electrical vin, vout, vsense_in, vsense_out, n1, n2, n3, n4, gnd;

  // Supply Load Resistor
  my_res#(.R(1u)) rsupply(vin, n1);

  my_res#(.R(200u)) rwire_1(n1, n2);

  // Ceramic Bulk
  my_real_cap#(.C(330u), .ESL(200p), .ESR(2m)) c_electrolytic_bulk(n2, gnd);

  // Ceramic Bulk
  my_real_cap#(.C(88u), .ESL(135p), .ESR(1200u)) c_ceramic_bulk(n2, gnd);

  // Ceramic Socket
  my_real_cap#(.C(611u), .ESL(40p), .ESR(300u)) c_ceramic_socket(n3, gnd);

  //my_res#(.R(100k)) r1(n2, gnd);
  //my_res#(.R(100k)) ra(n1, gnd);
  //my_res#(.R(100k)) rb(n3, gnd);

  // Motherboard traces
  pcb_trace#(.ESL(270p), .ESR(1000u)) trace(n2, n3);

  // Package
  pcb_trace#(.ESL(12p), .ESR(400u)) package(n3, n4);

  // output sense resistor
  my_res#(.R(1u)) rout(n4, vout);

  analog begin
    V(vsense_in, gnd) <+ V(n1, gnd);
    V(vsense_out, gnd) <+ V(n4, gnd);
  end
endmodule

module board_package_mobile (vin, vout, vsense_in, vsense_out, gnd);
	inout vin, vout, gnd;
  output vsense_in, vsense_out;
	electrical vin, vout, vsense_in, vsense_out, n1, n2, n3, n4, gnd;

  // Supply Load Resistor
  my_res#(.R(1u)) rsupply(vin, n1);

  my_res#(.R(200u)) rwire(n1, n2);

  // Ceramic Bulk
  my_real_cap#(.C(100u), .ESL(200p), .ESR(2m)) c_electrolytic_bulk(n2, gnd);

  // Ceramic Bulk
  my_real_cap#(.C(60u), .ESL(135p), .ESR(1200u)) c_ceramic_bulk(n2, gnd);

  // Ceramic Socket
  my_real_cap#(.C(10u), .ESL(40p), .ESR(300u)) c_ceramic_socket(n3, gnd);

  //my_res#(.R(100k)) r1(n2, gnd);
  //my_res#(.R(100k)) ra(n1, gnd);
  //my_res#(.R(100k)) rb(n3, gnd);

  // Motherboard traces
  pcb_trace#(.ESL(90p), .ESR(1m)) trace(n2, n3);

  // Package
  pcb_trace#(.ESL(12p), .ESR(400u)) package(n3, n4);

  // output sense resistor
  my_res#(.R(1u)) rout(n4, vout);

  analog begin
    V(vsense_in, gnd) <+ V(n1, gnd);
    V(vsense_out, gnd) <+ V(n4, gnd);
  end
endmodule

module board_package_embedded (vin, vout, vsense_in, vsense_out, gnd);
	inout vin, vout, gnd;
  output vsense_in, vsense_out;
	electrical vin, vout, vsense_in, vsense_out, n1, n2, n3, n4, n5, gnd;

  // Supply Load Resistor
  my_res#(.R(1u)) rsupply(vin, n1);

  my_res#(.R(200u)) rwire(n1, n2);

  // Supply Bulk Ceramic Caps
  my_real_cap#(.C(20u), .ESL(275p), .ESR(2.5m)) c_ceramic_supply_bulk(n2, gnd);

  // Ceramic Bulk
  my_real_cap#(.C(4.7u), .ESL(550p), .ESR(5m)) c_device_bulk(n2, gnd);

  // Ceramic Socket
  my_real_cap#(.C(1.5u), .ESL(34p), .ESR(267u)) c_ceramic_socket(n3, gnd);

  // Motherboard traces
  pcb_trace#(.ESL(740p), .ESR(10m)) trace(n2, n3);

  // Motherboard traces
  pcb_trace#(.ESL(30p), .ESR(1m)) trace_2(n3, n4);

  // Package
  pcb_trace#(.ESL(12p), .ESR(400u)) package(n4, n5);

  // output sense resistor
  my_res#(.R(1u)) rout(n5, vout);

  analog begin
    V(vsense_in, gnd) <+ V(n1, gnd);
    V(vsense_out, gnd) <+ V(n5, gnd);
  end
endmodule

module board_package_perf_uc (vin, vout, vsense_in, vsense_out, gnd);
	inout vin, vout, gnd;
  output vsense_in, vsense_out;
	electrical vin, vout, vsense_in, vsense_out, n1, n2, n3, n4,n5, gnd;

  // Supply Load Resistor
  my_res#(.R(1u)) rsupply(vin, n1);

  my_res#(.R(200u)) rwire(n1, n2);

  // Supply Bulk Ceramic Caps
  my_real_cap#(.C(20u), .ESL(275p), .ESR(2.5m)) c_ceramic_supply_bulk(n2, gnd);

  // Ceramic Bulk
  my_real_cap#(.C(4.7u), .ESL(550p), .ESR(5m)) c_device_bulk(n3, gnd);

  // Ceramic Socket
  my_real_cap#(.C(1.5u), .ESL(34p), .ESR(267u)) c_ceramic_socket(n4, gnd);

  // Motherboard traces
  pcb_trace#(.ESL(740p), .ESR(10m)) trace(n2, n3);

  // Motherboard traces
  pcb_trace#(.ESL(30p), .ESR(1m)) trace_2(n3, n4);

  // Package
  pcb_trace#(.ESL(12p), .ESR(400u)) package(n4, n5);

  // output sense resistor
  my_res#(.R(1u)) rout(n5, vout);

  analog begin
    V(vsense_in, gnd) <+ V(n1, gnd);
    V(vsense_out, gnd) <+ V(n5, gnd);
  end
endmodule

module board_package_lp (vin, vout, vsense_in, vsense_out, gnd);
	inout vin, vout, gnd;
  output vsense_in, vsense_out;
	electrical vin, vout, vsense_in, vsense_out, n1, n2, n3, n4,n5, gnd;

  // Supply Load Resistor
  my_res#(.R(1u)) rsupply(vin, n1);

  my_res#(.R(200u)) rwire(n1, n2);

  // Supply Bulk Ceramic Caps
  my_real_cap#(.C(10u), .ESL(275p), .ESR(2.5m)) c_ceramic_supply_bulk(n2, gnd);

  // Ceramic Bulk
  my_real_cap#(.C(4.7u), .ESL(550p), .ESR(5m)) c_device_bulk(n3, gnd);

  // Ceramic Socket
  my_real_cap#(.C(800n), .ESL(63p), .ESR(500u)) c_ceramic_socket(n4, gnd);

  // Motherboard traces
  pcb_trace#(.ESL(12p), .ESR(1m)) trace(n2, n3);

  // Motherboard traces
  pcb_trace#(.ESL(12p), .ESR(1m)) trace_2(n3, n4);

  // Package
  pcb_trace#(.ESL(12p), .ESR(400u)) package(n4, n5);

  // output sense resistor
  my_res#(.R(1u)) rout(n5, vout);

  analog begin
    V(vsense_in, gnd) <+ V(n1, gnd);
    V(vsense_out, gnd) <+ V(n5, gnd);
  end
endmodule

`endif // INTEL_PDN_VAMS
