/*
 * Copyright (c) 2020 Andrew Smith
 *
 * Permission is hereby granted, free of charge, to any person obtaining a copy
 * of this software and associated documentation files (the "Software"), to deal
 * in the Software without restriction, including without limitation the rights
 * to use, copy, modify, merge, publish, distribute, sublicense, and/or sell
 * copies of the Software, and to permit persons to whom the Software is
 * furnished to do so, subject to the following conditions:
 *
 * The above copyright notice and this permission notice shall be included in all
 * copies or substantial portions of the Software.
 *
 * THE SOFTWARE IS PROVIDED "AS IS", WITHOUT WARRANTY OF ANY KIND, EXPRESS OR
 * IMPLIED, INCLUDING BUT NOT LIMITED TO THE WARRANTIES OF MERCHANTABILITY,
 * FITNESS FOR A PARTICULAR PURPOSE AND NONINFRINGEMENT. IN NO EVENT SHALL THE
 * AUTHORS OR COPYRIGHT HOLDERS BE LIABLE FOR ANY CLAIM, DAMAGES OR OTHER
 * LIABILITY, WHETHER IN AN ACTION OF CONTRACT, TORT OR OTHERWISE, ARISING FROM,
 * OUT OF OR IN CONNECTION WITH THE SOFTWARE OR THE USE OR OTHER DEALINGS IN THE
 * SOFTWARE.
 */

/*
 * Verilog-AMS HDL
 *
 * This is a single order power distribution network stage.
 */

`ifndef PDN_STAGE_VAMS
`define PDN_STAGE_VAMS

`include "constants.vams"
`include "disciplines.vams"
`include "resistor.vams"
`include "inductor.vams"
`include "capacitor.vams"

`timescale 1ps/1ps

/*
 * Module pdn_stage
 *
 *  Models the L,C,R of a power supply stage.
 *
 *    vin - Input Voltage (From Supply)
 *    vout - Output Voltage (To Load)
 *    gnd - ground net
 *
 *    Parameter C_STAGE - Capacitor Val
 *    Parameter CESR - ESR of Capacitor
 *    Parameter CESL - ESL of Capacitor
 *    Parameter N_CAP - Number of Capacitors
 *    Parameter L_STAGE - Inductor Value
 *    Parameter R_STAGE - R Value
 */
module pdn_stage(vin, vout, gnd);
  inout vin, vout, gnd;
  electrical vin, n1, vout, gnd;
  genvar i;

  parameter real C_STAGE=25n;
  parameter real CESR=1n;
  parameter real CESL=1p;
  parameter integer N_CAP=4;
  parameter real L_STAGE=1p;
  parameter real R_STAGE=1n;

  my_ind#(.L(L_STAGE)) l_stage(vin, n1);
  my_res#(.R(R_STAGE)) r_stage(n1,vout);

  generate
    for(i = 0; i < N_CAP; i=i+1) begin
      my_real_cap#(.C(C_STAGE), .ESR(CESR), .ESL(CESL)) c_stage(vout, gnd);
    end
  endgenerate
endmodule

`endif // PDN_STAGE_VAMS
