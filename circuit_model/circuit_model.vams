/*
 * Copyright (c) 2020 Andrew Smith
 *
 * Permission is hereby granted, free of charge, to any person obtaining a copy
 * of this software and associated documentation files (the "Software"), to deal
 * in the Software without restriction, including without limitation the rights
 * to use, copy, modify, merge, publish, distribute, sublicense, and/or sell
 * copies of the Software, and to permit persons to whom the Software is
 * furnished to do so, subject to the following conditions:
 *
 * The above copyright notice and this permission notice shall be included in all
 * copies or substantial portions of the Software.
 *
 * THE SOFTWARE IS PROVIDED "AS IS", WITHOUT WARRANTY OF ANY KIND, EXPRESS OR
 * IMPLIED, INCLUDING BUT NOT LIMITED TO THE WARRANTIES OF MERCHANTABILITY,
 * FITNESS FOR A PARTICULAR PURPOSE AND NONINFRINGEMENT. IN NO EVENT SHALL THE
 * AUTHORS OR COPYRIGHT HOLDERS BE LIABLE FOR ANY CLAIM, DAMAGES OR OTHER
 * LIABILITY, WHETHER IN AN ACTION OF CONTRACT, TORT OR OTHERWISE, ARISING FROM,
 * OUT OF OR IN CONNECTION WITH THE SOFTWARE OR THE USE OR OTHER DEALINGS IN THE
 * SOFTWARE.
 */

/*
 * Verilog-AMS HDL
 *
 * circuit_model
 *
 * Top level circuit model.
 */

`ifndef CIRCUIT_MODEL_VAMS
`define CIRCUIT_MODEL_VAMS

`include "constants.vams"
`include "load.vams"
`include "disciplines.vams"
`include "intel_pdn.vams"
`include "arm_pdn.vams"
`include "harvard_pdn.vams"
`include "sources.vams"
`include "capacitor.vams"
`include "inductor.vams"
`include "resistor.vams"
`include "predictive_supply.vams"

`timescale 1ps/1ps

//`define ARM
//`define HARVARD
//`define INTEL_M
//`define INTEL_DT
`ifndef RF_TIME
`define RF_TIME 250p
`endif

`ifndef PTIME
`define PTIME 2500
`endif

//`define VERBOSE

/*
 * Module circuit_model
 *
 *  This module is the top level module, it contains the driver code for the
 *  interface between the driver process and the circuit simulation. The
 */
module circuit_model();
  // Top Level Signals
  electrical vin, iin, gnd, vout, iout, vvrm, vpcb, vpackage, vdie, vset;

  // Gem5 Interface Signals
  real v_set;
  electrical proc_load, prediction;
  real _proc_load, _prediction;
  reg prediction_enable;
  reg term_sim;
  reg retval;
  integer time_to_next;
  integer last_time;
  real vout_mean;
  real _vout_mean;

  // Logging
  real _vvrm, _vpcb, _vpackage, _vdie, _iin, _iout;

  // Supply Model
  my_vcvs supply(.p(vin), .n(gnd), .vp(vset), .vn(gnd));

`ifdef ARM
  // ARM Paper Model
  arm_power_distribution_network pdn(.vin(vin), .vout(vout), .gnd(gnd), .vvrm(vvrm), .vpcb(vpcb), .vpack(vpackage), .vdie(vdie), .iin(iin), .iout(iout));
`elsif HARVARD
  // Harvard PDN Model
  harvard_power_distribution_network pdn(.vin(vin), .vout(vout), .gnd(gnd), .vvrm(vvrm), .vpcb(vpcb), .vpack(vpackage), .vdie(vdie), .iin(iin), .iout(iout));
`elsif HARVARD_M
  // Harvard PDN Model
  harvard_power_distribution_network_mobile pdn(.vin(vin), .vout(vout), .gnd(gnd), .vvrm(vvrm), .vpcb(vpcb), .vpack(vpackage), .vdie(vdie), .iin(iin), .iout(iout));
`elsif HARVARD_L
  // Harvard PDN Model
  harvard_power_distribution_network_laptop pdn(.vin(vin), .vout(vout), .gnd(gnd), .vvrm(vvrm), .vpcb(vpcb), .vpack(vpackage), .vdie(vdie), .iin(iin), .iout(iout));
`elsif HARVARD_D
  // Harvard PDN Model
  harvard_power_distribution_network_desktop pdn(.vin(vin), .vout(vout), .gnd(gnd), .vvrm(vvrm), .vpcb(vpcb), .vpack(vpackage), .vdie(vdie), .iin(iin), .iout(iout));
`elsif INTEL_M
  // Intel Mobile
  intel_power_distribution_network_m pdn(.vin(vin), .vout(vout), .gnd(gnd), .vvrm(vvrm), .vpcb(vpcb), .vpack(vpackage), .vdie(vdie), .iin(iin), .iout(iout));
`elsif INTEL_DT
  // Intel Desktop
  intel_power_distribution_network_dt pdn(.vin(vin), .vout(vout), .gnd(gnd), .vvrm(vvrm), .vpcb(vpcb), .vpack(vpackage), .vdie(vdie), .iin(iin), .iout(iout));
`else
  // Default to harvard model
  harvard_power_distribution_network pdn(.vin(vin), .vout(vout), .gnd(gnd), .vvrm(vvrm), .vpcb(vpcb), .vpack(vpackage), .vdie(vdie), .iin(iin), .iout(iout));
`endif

  // Processor Load
  processor#(.DT(`RF_TIME)) proc(.p(vout), .n(gnd), .i(proc_load));

  analog begin
    V(gnd) <+ 0.0;
    V(vset) <+ v_set;
    _vvrm = V(vvrm, gnd);
    _vpcb = V(vpcb, gnd);
    _vpackage = V(vpackage, gnd);
    _vdie = V(vdie, gnd);
    _iout = V(iout, gnd);
    _iin = V(iin, gnd);
    V(proc_load, gnd) <+ _proc_load;
    V(prediction, gnd) <+ _prediction;
  end

  initial begin
    // Create a shared memory region to communicate with driver process
    retval = $create_shm(1, `SHM_NAME);

    // Initial values
    _vout_mean = 0.0;
    vout_mean = 0.0;
    _proc_load = 1.0;
    _prediction = 1.0;
    time_to_next = 0;
    last_time = 0;

    // Main Loop
    while(1) begin
      if(last_time >= time_to_next) begin
        last_time = 0;
        vout_mean = _vout_mean/(time_to_next + 1.0);
        $wait_driver_data;
        // Get signals from driver process
        v_set = $get_voltage_setpoint();
        _proc_load = $get_load();
        _prediction = $get_prediction();
        prediction_enable = $get_enable();
        time_to_next = $get_time_to_next();
        term_sim = $get_terminate_simulation();
        $ack_driver_data;
        // Send signals back to driver process
        retval = $send_voltage(vout_mean);
        retval = $send_current(_iout);
        $ack_simulation;
        if(term_sim != 0) begin
          // Cleanup
          $destroy_shm;
          $finish;
        end
        _vout_mean = 0.0;
      end
      // Clear enable signal 10 time units after setting it
      if(last_time >= 10) begin
        prediction_enable = 0;
      end
      _vout_mean = _vout_mean + _vdie;
      last_time = last_time + 1;
      // Write outpput values
      if($time % `PTIME) begin
`ifdef VERBOSE
        $display("%d,%f,%f,%f,%f,%f,%f,%f,%f,%f,%d,%f,%d,%f", $time, _vvrm, _vpcb, _vpackage, _vdie, _vout_mean, vout_mean, _iin, _iout, _proc_load, prediction_enable, _prediction, time_to_next, `RF_TIME);
`endif
      end
      #1;
    end
    // Cleanup
    $destroy_shm;
    $finish;
  end
endmodule

`endif // CIRCUIT_MODEL_VAMS
