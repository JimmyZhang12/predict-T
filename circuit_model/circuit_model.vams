/*
 * Copyright (c) 2020 Andrew Smith
 *
 * Permission is hereby granted, free of charge, to any person obtaining a copy
 * of this software and associated documentation files (the "Software"), to deal
 * in the Software without restriction, including without limitation the rights
 * to use, copy, modify, merge, publish, distribute, sublicense, and/or sell
 * copies of the Software, and to permit persons to whom the Software is
 * furnished to do so, subject to the following conditions:
 *
 * The above copyright notice and this permission notice shall be included in all
 * copies or substantial portions of the Software.
 *
 * THE SOFTWARE IS PROVIDED "AS IS", WITHOUT WARRANTY OF ANY KIND, EXPRESS OR
 * IMPLIED, INCLUDING BUT NOT LIMITED TO THE WARRANTIES OF MERCHANTABILITY,
 * FITNESS FOR A PARTICULAR PURPOSE AND NONINFRINGEMENT. IN NO EVENT SHALL THE
 * AUTHORS OR COPYRIGHT HOLDERS BE LIABLE FOR ANY CLAIM, DAMAGES OR OTHER
 * LIABILITY, WHETHER IN AN ACTION OF CONTRACT, TORT OR OTHERWISE, ARISING FROM,
 * OUT OF OR IN CONNECTION WITH THE SOFTWARE OR THE USE OR OTHER DEALINGS IN THE
 * SOFTWARE.
 *
 * circuit_model.vams
 *
 * The main testbench for the power supply and power distribution model.
 *
 */

`include "constants.vams"
`include "disciplines.vams"
`include "board_package.vams"
`include "resistor.vams"
`include "predictive_supply.vams"

`timescale 1ns/1ns

`define SERVER
`define AVP
`define CYCLES 200

module variable_isrc(p,n,i);
  inout p,n,i;
  electrical p,n,i;
  analog begin
    I(p,n) <+ V(p) / V(i);
  end
endmodule

module variable_vsrc(p,n,v);
  inout p,n,v;
  electrical p,n,v;
  analog begin
    V(p,n) <+ V(v);
  end
endmodule

module circuit_model ();
  // Top Level Signals
  wire _l_clk, _l_rst, _l_pwm;
  wire [7:0] _l_e, _l_d;
  electrical n4, gnd, n3, n2, n1, vsense_out, vsense_in, _i_step;
  //electrical _en;

  // Gem5 Interface Signals
  real _v_set, _dr, _r, _r_last, _r_new, _prediction;
  reg _enable;
  electrical _ve_set, _vr_last;
  reg _term_sim;
  real _v_next;

  // for logging:
  real v_vout, i_vout, v_vin, i_vin;

  // Modules
  //variable_vsrc supply(.p(n1), .n(gnd), .v(_ve_set));
  simple_buck_model supply(.vid(_ve_set),
                           ._i_step(_i_step),
                           .vout(n1),
                           .en(_enable));
  my_res#(.R(1u)) rsensea(.p(n1), .n(n3));
`ifdef SERVER
  board_package_intel_server filter(.vin(n3), .vout(n4), .gnd(gnd), .vsense_in(vsense_in), .vsense_out(vsense_out));
`endif
`ifdef LAPTOP
  board_package_laptop filter(.vin(n3), .vout(n4), .gnd(gnd), .vsense_in(vsense_in), .vsense_out(vsense_out));
`endif
`ifdef MOBILE
  board_package_mobile filter(.vin(n3), .vout(n4), .gnd(gnd), .vsense_in(vsense_in), .vsense_out(vsense_out));
`endif
`ifdef EMBEDDED
  board_package_embedded filter(.vin(n3), .vout(n4), .gnd(gnd), .vsense_in(vsense_in), .vsense_out(vsense_out));
`endif
`ifdef PERF_UC
  board_package_perf_uc filter(.vin(n3), .vout(n4), .gnd(gnd), .vsense_in(vsense_in), .vsense_out(vsense_out));
`endif
`ifdef LP_UC
  board_package_lp filter(.vin(n3), .vout(n4), .gnd(gnd), .vsense_in(vsense_in), .vsense_out(vsense_out));
`endif
  my_res#(.R(1u)) rsenseb(.p(n4), .n(n2));
  variable_isrc load(.p(n2), .n(gnd), .i(_vr_last));

  analog begin
    V(gnd) <+ 0.0;
    _v_next = V(n4);
    V(_vr_last) <+ _r;
    V(_i_step) <+ _prediction;
    //V(_en) <+ _enable;

`ifdef SERVER
`ifdef IDEAL
    V(_ve_set) <+ _v_set + (1/_r_last)*801u;
`endif
`ifdef AVP
    V(_ve_set) <+ _v_set;
`endif
`endif
`ifdef LAPTOP
`ifdef IDEAL
    V(_ve_set) <+ _v_set + (1/_r_last)*1601u;
`endif
`ifdef AVP
    V(_ve_set) <+ _v_set;
`endif
`endif
`ifdef MOBILE
`ifdef IDEAL
    V(_ve_set) <+ _v_set + (1/_r_last)*1601u;
`endif
`ifdef AVP
    V(_ve_set) <+ _v_set;
`endif
`endif
`ifdef EMBEDDED
`ifdef IDEAL
    V(_ve_set) <+ _v_set + (1/_r_last)*11m;
`endif
`ifdef AVP
    V(_ve_set) <+ _v_set;
`endif
`endif
`ifdef PERF_UC
`ifdef IDEAL
    V(_ve_set) <+ _v_set + (1/_r_last)*11m;
`endif
`ifdef AVP
    V(_ve_set) <+ _v_set;
`endif
`endif
`ifdef LP_UC
`ifdef IDEAL
    V(_ve_set) <+ _v_set + (1/_r_last)*2m;
`endif
`ifdef AVP
    V(_ve_set) <+ _v_set;
`endif
`endif

    v_vout = V(vsense_out, gnd);
    i_vout = I(n4, n2);
    v_vin = V(vsense_in, gnd);
    i_vin = I(n1, n3);
  end

  initial begin
    $create_shm(1, `SHM_NAME);
    _r_last = 1;
    _r_new = 1;
    _r = 1;
    _dr = 1;
    while(1) begin
      if($time % `STEP_SIZE == 0) begin
        $wait_driver_data;
        _v_set = $get_voltage_setpoint();
        _r_last = _r_new;
        _r_new = $get_effective_resistance();
        _dr = abs(_r_last - _r_new)/`CYCLES;
        _prediction = $get_prediction();
        _enable = $get_enable();
        _term_sim = $get_terminate_simulation();
        //$display("%d,%f,%f,%f,%f", _v_set, _r_last, _prediction, _enable, _term_sim);
        $ack_driver_data;
        $send_voltage(v_vout);
        $send_current(i_vout);
        $ack_simulation;
        if(_term_sim != 0) begin
          $destroy_shm;
          $finish;
        end
      end
      if($time % `STEP_SIZE == 10) begin
        _enable = 0;
      end
      if(_r_last < _r_new) begin
        _r = min(_r + _dr, _r_new);
      end
      else if(_r_last >= _r_new) begin
        _r = max(_r - _dr, _r_new);
      end
      $display("%d,%f,%f,%f,%f,%f,%f,%f,%f,%d,%f", $time, v_vin, i_vin, v_vout, i_vout, _r, _r_last, _r_new, _dr, _enable, _prediction);
      #1;
    end
    $destroy_shm;
    $finish;
  end
endmodule
