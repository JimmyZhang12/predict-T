/*
 * Copyright (c) 2020 Andrew Smith
 *
 * Permission is hereby granted, free of charge, to any person obtaining a copy
 * of this software and associated documentation files (the "Software"), to deal
 * in the Software without restriction, including without limitation the rights
 * to use, copy, modify, merge, publish, distribute, sublicense, and/or sell
 * copies of the Software, and to permit persons to whom the Software is
 * furnished to do so, subject to the following conditions:
 *
 * The above copyright notice and this permission notice shall be included in all
 * copies or substantial portions of the Software.
 *
 * THE SOFTWARE IS PROVIDED "AS IS", WITHOUT WARRANTY OF ANY KIND, EXPRESS OR
 * IMPLIED, INCLUDING BUT NOT LIMITED TO THE WARRANTIES OF MERCHANTABILITY,
 * FITNESS FOR A PARTICULAR PURPOSE AND NONINFRINGEMENT. IN NO EVENT SHALL THE
 * AUTHORS OR COPYRIGHT HOLDERS BE LIABLE FOR ANY CLAIM, DAMAGES OR OTHER
 * LIABILITY, WHETHER IN AN ACTION OF CONTRACT, TORT OR OTHERWISE, ARISING FROM,
 * OUT OF OR IN CONNECTION WITH THE SOFTWARE OR THE USE OR OTHER DEALINGS IN THE
 * SOFTWARE.
 */

/*
 * Verilog-AMS HDL
 *
 * circuit_model
 *
 * Top level circuit model.
 */

`ifndef CIRCUIT_MODEL_VAMS
`define CIRCUIT_MODEL_VAMS

`include "constants.vams"
`include "load.vams"
`include "disciplines.vams"
`include "intel_pdn.vams"
`include "arm_pdn.vams"
`include "harvard_pdn.vams"
`include "sources.vams"
`include "capacitor.vams"
`include "inductor.vams"
`include "resistor.vams"
`include "predictive_supply.vams"

`timescale 1ns/1ps

//`define INTEL_SERVER_PDN
//`define ARM_PDN
`define HARVARD_PDN
`define CYCLES 200

/*
 * Module circuit_model
 *
 *  This module is the top level module, it contains the driver code for the
 *  interface between the driver process and the circuit simulation. The
 */
module circuit_model();
  // Top Level Signals
  wire _l_clk, _l_rst, _l_pwm;
  wire [7:0] _l_e, _l_d;
  electrical vin, iin, gnd, vout, iout, vvrm, vpcb, vpackage, vdie, _i_step, vset;

  // Gem5 Interface Signals
  real _v_set, _dr, _r, _r_last, _r_new, _prediction;
  reg _enable;
  electrical _vr_last;
  reg _term_sim;
  reg retval;

  // Logging
  real _vvrm, _vpcb, _vpackage, _vdie, _iin, _iout;

  // Supply Model
  my_vcvs supply(.p(vin), .n(gnd), .vp(vset), .vn(gnd));

`ifdef ARM_PDN
  arm_power_distribution_network pdn(.vin(vin), .vout(vout), .gnd(gnd), .vvrm(vvrm), .vpcb(vpcb), .vpack(vpackage), .vdie(vdie), .iin(iin), .iout(iout));
`endif
`ifdef HARVARD_PDN
  harvard_power_distribution_network pdn(.vin(vin), .vout(vout), .gnd(gnd), .vvrm(vvrm), .vpcb(vpcb), .vpack(vpackage), .vdie(vdie), .iin(iin), .iout(iout));
`endif

  // Processor Load
  processor proc(.p(vout), .n(gnd), .r(_vr_last));

  analog begin
    V(gnd) <+ 0.0;
    V(_vr_last) <+ _r;
    V(_i_step) <+ _prediction;

    V(vset) <+ _v_set;

    _vvrm = V(vvrm, gnd);
    _vpcb = V(vpcb, gnd);
    _vpackage = V(vpackage, gnd);
    _vdie = V(vdie, gnd);
    _iout = V(iout, gnd);
    _iin = V(iin, gnd);
  end

  initial begin
    // Create a shared memory region to communicate with driver process
    retval = $create_shm(1, `SHM_NAME);

    // Initial values
    _r_last = 1;
    _r_new = 1;
    _r = 1;
    _dr = 1;

    // Main Loop
    while(1) begin
      // Sync every `STEP_SIZE time units
      if($time % `STEP_SIZE == 0) begin
        $wait_driver_data;
        // Get signals from driver process
        _v_set = $get_voltage_setpoint();
        _r_last = _r_new;
        _r_new = $get_effective_resistance();
        _dr = abs(_r_last - _r_new)/`CYCLES;
        _prediction = $get_prediction();
        _enable = $get_enable();
        _term_sim = $get_terminate_simulation();
        $ack_driver_data;
        // Send signals back to driver process
        retval = $send_voltage(_vdie);
        retval = $send_current(_iout);
        $ack_simulation;
        if(_term_sim != 0) begin
          // Cleanup
          $destroy_shm;
          $finish;
        end
      end
      // Clear enable signal 10 time units after setting it
      if($time % `STEP_SIZE == 10) begin
        _enable = 0;
      end

      // Bring resistace to the new setpoint at the simulation timescale
      if(_r_last < _r_new) begin
        _r = min(_r + _dr, _r_new);
      end
      else if(_r_last >= _r_new) begin
        _r = max(_r - _dr, _r_new);
      end

      // Write outpput values
      $display("%d,%f,%f,%f,%f,%f,%f,%f,%f,%f,%f,%d,%f", $time, _vvrm, _vpcb, _vpackage, _vdie, _iin, _iout, _r, _r_last, _r_new, _dr, _enable, _prediction);
      #1;
    end
    // Cleanup
    $destroy_shm;
    $finish;
  end
endmodule

`endif // CIRCUIT_MODEL_VAMS
