/*
 * Copyright (c) 2020 Andrew Smith
 *
 * Permission is hereby granted, free of charge, to any person obtaining a copy
 * of this software and associated documentation files (the "Software"), to deal
 * in the Software without restriction, including without limitation the rights
 * to use, copy, modify, merge, publish, distribute, sublicense, and/or sell
 * copies of the Software, and to permit persons to whom the Software is
 * furnished to do so, subject to the following conditions:
 *
 * The above copyright notice and this permission notice shall be included in all
 * copies or substantial portions of the Software.
 *
 * THE SOFTWARE IS PROVIDED "AS IS", WITHOUT WARRANTY OF ANY KIND, EXPRESS OR
 * IMPLIED, INCLUDING BUT NOT LIMITED TO THE WARRANTIES OF MERCHANTABILITY,
 * FITNESS FOR A PARTICULAR PURPOSE AND NONINFRINGEMENT. IN NO EVENT SHALL THE
 * AUTHORS OR COPYRIGHT HOLDERS BE LIABLE FOR ANY CLAIM, DAMAGES OR OTHER
 * LIABILITY, WHETHER IN AN ACTION OF CONTRACT, TORT OR OTHERWISE, ARISING FROM,
 * OUT OF OR IN CONNECTION WITH THE SOFTWARE OR THE USE OR OTHER DEALINGS IN THE
 * SOFTWARE.
 */

/*
 * Verilog-AMS HDL
 *
 * capacitor.vams
 *
 * Ideal and Realistic Capacitor VAMS Model
 *
 */

`ifndef MY_CAPACITOR_VAMS
`define MY_CAPACITOR_VAMS

`include "constants.vams"
`include "disciplines.vams"
`include "resistor.vams"
`include "inductor.vams"

`timescale 1ns/1ps

/*
 * Module my_cap
 *
 *  Ideal Capacitor Model
 *
 *    p - Positive Terminal
 *    n - Negative Terminal
 *
 *    Parameter C - Capacitance
 */
module my_cap(p, n);
  inout p, n;
  electrical p, n;
  parameter real C=0;

  analog begin
    I(p,n) <+ C * ddt(V(p,n));
  end
endmodule

/*
 * Module my_real_cap
 *
 *  Realistic Capacitor Model
 *
 *    p - Positive Terminal
 *    n - Negative Terminal
 *
 *    Parameter C - Capacitance
 *    Parameter ESL - Series Inductance
 *    Parameter ESR - Series Resistance
 *    Parameter RL - Leakage
 */
module my_real_cap(p, n);
  inout p, n;
  electrical p, n;
  electrical n1, n2;
  parameter real C=1u;
  parameter real ESL=0;
  parameter real ESR=1u;
  parameter real RL=10M;

  //my_res#(.R(RL)) r_leak(p, n);
  my_cap#(.C(C)) c_deal(p, n1);
  my_ind#(.L(ESL)) l_esl(n1, n2);
  my_res#(.R(ESR)) r_esr(n2, n);
endmodule

`endif // MY_CAPACITOR_VAMS
