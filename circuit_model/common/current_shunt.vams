/*
 * Copyright (c) 2020 Andrew Smith
 *
 * Permission is hereby granted, free of charge, to any person obtaining a copy
 * of this software and associated documentation files (the "Software"), to deal
 * in the Software without restriction, including without limitation the rights
 * to use, copy, modify, merge, publish, distribute, sublicense, and/or sell
 * copies of the Software, and to permit persons to whom the Software is
 * furnished to do so, subject to the following conditions:
 *
 * The above copyright notice and this permission notice shall be included in all
 * copies or substantial portions of the Software.
 *
 * THE SOFTWARE IS PROVIDED "AS IS", WITHOUT WARRANTY OF ANY KIND, EXPRESS OR
 * IMPLIED, INCLUDING BUT NOT LIMITED TO THE WARRANTIES OF MERCHANTABILITY,
 * FITNESS FOR A PARTICULAR PURPOSE AND NONINFRINGEMENT. IN NO EVENT SHALL THE
 * AUTHORS OR COPYRIGHT HOLDERS BE LIABLE FOR ANY CLAIM, DAMAGES OR OTHER
 * LIABILITY, WHETHER IN AN ACTION OF CONTRACT, TORT OR OTHERWISE, ARISING FROM,
 * OUT OF OR IN CONNECTION WITH THE SOFTWARE OR THE USE OR OTHER DEALINGS IN THE
 * SOFTWARE.
 */

/*
 * Verilog-AMS HDL
 *
 * current_shunt.vams
 *
 * Current_shunt
 */

`include "constants.vams"
`include "disciplines.vams"

module buck (pwm,in, out);
	input pwm;
  inout in, out;
	electrical in, out;
  branch (in,out) variable_current_source;

  parameter real DT=10p;

  //Rate of rise and fall can be different
  //parameter real DT_fall
  parameter current_max = 10;
	real switch;

	always @(pwm) begin
		if (pwm == 1'b1) switch = 1;
		else switch = 0;
	end

	analog begin
    I(variable_current_source) <+ transition(current_max*switch, 0p, DT, DT);
	end

endmodule
