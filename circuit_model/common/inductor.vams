/*
 * Copyright (c) 2020 Andrew Smith
 *
 * Permission is hereby granted, free of charge, to any person obtaining a copy
 * of this software and associated documentation files (the "Software"), to deal
 * in the Software without restriction, including without limitation the rights
 * to use, copy, modify, merge, publish, distribute, sublicense, and/or sell
 * copies of the Software, and to permit persons to whom the Software is
 * furnished to do so, subject to the following conditions:
 *
 * The above copyright notice and this permission notice shall be included in all
 * copies or substantial portions of the Software.
 *
 * THE SOFTWARE IS PROVIDED "AS IS", WITHOUT WARRANTY OF ANY KIND, EXPRESS OR
 * IMPLIED, INCLUDING BUT NOT LIMITED TO THE WARRANTIES OF MERCHANTABILITY,
 * FITNESS FOR A PARTICULAR PURPOSE AND NONINFRINGEMENT. IN NO EVENT SHALL THE
 * AUTHORS OR COPYRIGHT HOLDERS BE LIABLE FOR ANY CLAIM, DAMAGES OR OTHER
 * LIABILITY, WHETHER IN AN ACTION OF CONTRACT, TORT OR OTHERWISE, ARISING FROM,
 * OUT OF OR IN CONNECTION WITH THE SOFTWARE OR THE USE OR OTHER DEALINGS IN THE
 * SOFTWARE.
 */

/*
 * Verilog-AMS HDL
 *
 * Ideal and Realistic Inductor VAMS Model
 *
 */

`ifndef MY_INDUCTOR_VAMS
`define MY_INDUCTOR_VAMS

`include "constants.vams"
`include "disciplines.vams"
`include "resistor.vams"

`timescale 1ns/1ps

module my_ind(p, n);
  inout p, n;
  electrical p, n;
  parameter real L=0;

  analog begin
    V(p,n) <+ L * ddt(I(p,n));
  end
endmodule

module my_real_ind(p, n);
  inout p, n;
  electrical p, n;
  parameter real L=0;
  parameter real ESR=1u;

  my_ind#(.L(L)) LESL(p, n1);
  my_res#(.R(ESR)) RESR(n1, n);
endmodule

`endif // MY_INDUCTOR_VAMS
