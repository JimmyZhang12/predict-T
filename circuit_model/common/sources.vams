/*
 * Copyright (c) 2020 Andrew Smith
 *
 * Permission is hereby granted, free of charge, to any person obtaining a copy
 * of this software and associated documentation files (the "Software"), to deal
 * in the Software without restriction, including without limitation the rights
 * to use, copy, modify, merge, publish, distribute, sublicense, and/or sell
 * copies of the Software, and to permit persons to whom the Software is
 * furnished to do so, subject to the following conditions:
 *
 * The above copyright notice and this permission notice shall be included in all
 * copies or substantial portions of the Software.
 *
 * THE SOFTWARE IS PROVIDED "AS IS", WITHOUT WARRANTY OF ANY KIND, EXPRESS OR
 * IMPLIED, INCLUDING BUT NOT LIMITED TO THE WARRANTIES OF MERCHANTABILITY,
 * FITNESS FOR A PARTICULAR PURPOSE AND NONINFRINGEMENT. IN NO EVENT SHALL THE
 * AUTHORS OR COPYRIGHT HOLDERS BE LIABLE FOR ANY CLAIM, DAMAGES OR OTHER
 * LIABILITY, WHETHER IN AN ACTION OF CONTRACT, TORT OR OTHERWISE, ARISING FROM,
 * OUT OF OR IN CONNECTION WITH THE SOFTWARE OR THE USE OR OTHER DEALINGS IN THE
 * SOFTWARE.
 */

/*
 * Verilog-AMS HDL
 *
 * sources.vams
 *
 * Collection of Voltage and Current sources
 */

`ifndef MY_SOURCES_VAMS
`define MY_SOURCES_VAMS

`include "constants.vams"
`include "disciplines.vams"

`timescale 1ps/1ps

/*
 * Module vcvs
 *
 *  Voltage Controlled Voltage Source (VCVS)
 *
 *    p - Positive Terminal
 *    n - Negative Terminal
 *    vp, vn - nodes to take voltage across
 *
 *    Parameter GAIN - Gain of the device
 */
module my_vcvs(p, n, vp, vn);
  inout p, n, vp, vn;
  electrical p, n, vp, vn;

  parameter real GAIN=1.0;

  analog begin
    V(p, n) <+ GAIN*V(vp, vn);
  end
endmodule

/*
 * Module ccvs
 *
 *  Current Controlled Voltage Source (CCVS)
 *
 *    p - Positive Terminal
 *    n - Negative Terminal
 *    vp, vn - nodes to take current across
 *
 *    Parameter GAIN - Gain of the device
 */
module my_ccvs(p, n, vp, vn);
  inout p, n, vp, vn;
  electrical p, n, vp, vn;

  parameter real GAIN=1.0;

  analog begin
    V(p, n) <+ GAIN*I(vp, vn);
  end
endmodule

/*
 * Module vccs
 *
 *  Voltage Controlled Current Source (VCCS)
 *
 *    p - Positive Terminal
 *    n - Negative Terminal
 *    vp, vn - nodes to take current across
 *
 *    Parameter GAIN - Gain of the device
 */
module my_vccs(p, n, vp, vn);
  inout p, n, vp, vn;
  electrical p, n, vp, vn;

  parameter real GAIN=1.0;

  analog begin
    I(p, n) <+ GAIN*V(vp, vn);
  end
endmodule

/*
 * Module cccs
 *
 *  Current Controlled Current Source (CCCS)
 *
 *    p - Positive Terminal
 *    n - Negative Terminal
 *    vp, vn - nodes to take current across
 *
 *    Parameter GAIN - Gain of the device
 */
module my_cccs(p, n, vp, vn);
  inout p, n, vp, vn;
  electrical p, n, vp, vn;

  parameter real GAIN=1.0;

  analog begin
    I(p, n) <+ GAIN*I(vp, vn);
  end
endmodule

`endif // MY_SOURCES_VAMS
