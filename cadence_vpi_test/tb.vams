`include "disciplines.vams"

module DAC6 (Din,Aout, Vdd,Vss);
  input [5:0] Din; // digital input bus
  output Aout; // analog output
  input Vdd,Vss; // reference supply for output
  electrical Aout,Vdd,Vss;
  parameter real tr=10n; // (sec) risetime for output changes
  parameter real rout=1k; // (ohms) output resistance
  real kout; // output as fraction of supply
  real vout; // continuous analog output voltage
  always begin
    kout = Din/63.0; // else compute scale factor for output
  @(Din); // repeat whenever Din changes
  end
  analog begin
    vout = V(Vdd,Vss)*transition(kout,0,tr,tr); // ramp to fraction of supply
    I(Aout,Vss) <+ (V(Aout,Vss)-vout)/rout; // drive output voltage+resistance
  end
endmodule

module DAC6_TB;
  electrical Aout,Vdd,Vss; // analog pins
  real Vsup,Vgnd,Tr; // control variables to drive analog supplies
  reg [5:0] Din; // digital input bus
  DAC6 DUT(Din,Aout, Vdd,Vss); // instanciate the digital to analog converter
  analog begin // analog drive description:
    V(Vdd) <+ transition(Vsup,0,Tr); // drive the analog supplies
    V(Vss) <+ transition(Vgnd,0,Tr); // using the control variables
  end
  initial begin // This is the sequential test procedure
    Din=0; // Initialize digital input bus to zero
    Vsup=3; Vgnd=0; // Initial 3 volt supply and ground voltage
    Tr=200n; // risetime for supply changes
    repeat(63) #50 Din=Din+1; // step Din thru all codes, incrementing every 50 ns
    #100 Din=8'b100000; // step to half scale input
    #100 Vsup=2.4; // Check that output follows supply midpoint
    #100 $hello;
    #101 $hello;
    #102 $hello;
    #103 $hello;
    #104 $hello;
    #105 $hello;
    #106 $hello;
    #107 $hello;
    #300 Vsup=3.0;
    #300 Vgnd=0.4; // Check that it follows negative reference too
    #300 Vgnd=0;
    #300 $finish; // done with testing
  end
endmodule
